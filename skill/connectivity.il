;;; connectivity.il - C08 pin/wire/net connectivity inspection
;;;
;;; Shared pin/wire/net connectivity helpers.

(defun _coco_conn_point_key (x y)
  (strcat (safeStr x) "," (safeStr y)))

(defun _coco_conn_string_contains (text needle)
  (let ((hay (safeStr text))
        (target (safeStr needle))
        (hay_len 0)
        (target_len 0)
        (idx 1)
        (found nil))
    (setq hay_len (strlen hay))
    (setq target_len (strlen target))
    (if (equal target_len 0)
      t
      (progn
        (while (and (not found) (leqp idx (add1 (difference hay_len target_len))))
          (when (equal (substring hay idx target_len) target)
            (setq found t))
          (setq idx (add1 idx)))
        found))))

(defun _coco_conn_string_ends_with (text suffix)
  (let ((hay (safeStr text))
        (tail (safeStr suffix))
        (hay_len 0)
        (tail_len 0))
    (setq hay_len (strlen hay))
    (setq tail_len (strlen tail))
    (and (leqp tail_len hay_len)
         (equal (substring hay (add1 (difference hay_len tail_len)) tail_len) tail))))

(defun _coco_conn_wire_dbid (wire)
  (let ((value (_coco_safe_apply 'cnGetWireDbId (list wire))))
    (if value
      (safeStr value)
      (safeStr (_coco_nth 0 wire)))))

(defun _coco_conn_wire_dbid_value (wire)
  (let ((value (_coco_safe_apply 'cnGetWireDbId (list wire))))
    (if value value (_coco_nth 0 wire))))

(defun _coco_conn_wire_x1 (wire)
  (let ((point (_coco_safe_apply 'cnGetWireXY1 (list wire)))
        (value nil))
    (when point
      (setq value (_coco_safe_apply 'cnGetPointX (list point))))
    (if value (safeStr value) (safeStr (_coco_nth 1 wire)))))

(defun _coco_conn_wire_y1 (wire)
  (let ((point (_coco_safe_apply 'cnGetWireXY1 (list wire)))
        (value nil))
    (when point
      (setq value (_coco_safe_apply 'cnGetPointY (list point))))
    (if value (safeStr value) (safeStr (_coco_nth 2 wire)))))

(defun _coco_conn_wire_x2 (wire)
  (let ((point (_coco_safe_apply 'cnGetWireXY2 (list wire)))
        (value nil))
    (when point
      (setq value (_coco_safe_apply 'cnGetPointX (list point))))
    (if value (safeStr value) (safeStr (_coco_nth 3 wire)))))

(defun _coco_conn_wire_y2 (wire)
  (let ((point (_coco_safe_apply 'cnGetWireXY2 (list wire)))
        (value nil))
    (when point
      (setq value (_coco_safe_apply 'cnGetPointY (list point))))
    (if value (safeStr value) (safeStr (_coco_nth 4 wire)))))

(defun _coco_conn_wire_p1 (wire)
  (_coco_conn_point_key (_coco_conn_wire_x1 wire) (_coco_conn_wire_y1 wire)))

(defun _coco_conn_wire_p2 (wire)
  (_coco_conn_point_key (_coco_conn_wire_x2 wire) (_coco_conn_wire_y2 wire)))

(defun _coco_conn_wire_touches_point (wire point_key)
  (or (equal (_coco_conn_wire_p1 wire) point_key)
      (equal (_coco_conn_wire_p2 wire) point_key)))

(defun _coco_conn_same_wire_geometry (left right)
  (let ((left_p1 (_coco_conn_wire_p1 left))
        (left_p2 (_coco_conn_wire_p2 left))
        (right_p1 (_coco_conn_wire_p1 right))
        (right_p2 (_coco_conn_wire_p2 right)))
    (or
      (and (equal left_p1 right_p1) (equal left_p2 right_p2))
      (and (equal left_p1 right_p2) (equal left_p2 right_p1)))))

(defun _coco_conn_props_for_wire (handle wire include_nets)
  (let ((wire_id nil)
        (wire_group nil)
        (select_result nil)
        (group "")
        (group_obj nil)
        (props nil)
        (result nil))
    (setq wire_id (_coco_conn_wire_dbid_value wire))
    (when wire_id
      (setq wire_group (_coco_safe_apply 'cnGroupObjects (list handle (list wire_id)))))
    (when wire_group
      (setq result
        (errset
          (_coco_send_cmd
            handle
            (if include_nets "include nets properties" "include properties"))
          nil))
      (when result
        (setq select_result (car result))
        (setq group (safeStr (_coco_safe_apply 'cnGetGroupName (list select_result))))
        (setq group_obj (_coco_safe_apply 'cnGetGroupedObjectSet (list select_result)))
        (when group_obj
          (setq props (_coco_safe_apply 'cnGetProps (list group_obj)))))
      (_coco_cleanup_iterator handle (_coco_make_iterator group nil)))
    props))

(setq _coco_conn_page_net_names nil)
(setq _coco_conn_page_signal_props nil)
(setq _coco_conn_page_named_wires nil)
(setq _coco_conn_named_wire_queries nil)

(defun _coco_conn_prop_attach_x (prop)
  (let ((point (_coco_safe_apply 'cnGetPropAttachXY (list prop)))
        (value nil))
    (when (not point)
      (setq point (_coco_safe_apply 'cnGetPropXY (list prop))))
    (when point
      (setq value (_coco_safe_apply 'cnGetPointX (list point))))
    (if value (safeStr value) "")))

(defun _coco_conn_prop_attach_y (prop)
  (let ((point (_coco_safe_apply 'cnGetPropAttachXY (list prop)))
        (value nil))
    (when (not point)
      (setq point (_coco_safe_apply 'cnGetPropXY (list prop))))
    (when point
      (setq value (_coco_safe_apply 'cnGetPointY (list point))))
    (if value (safeStr value) "")))

(defun _coco_conn_signal_prop_entry (prop)
  (list
    (safeGetProp prop "value")
    (_coco_conn_prop_attach_x prop)
    (_coco_conn_prop_attach_y prop)
    (_coco_prop_owner_dbid_string prop)
    (_coco_prop_owner_type_string prop)))

(defun _coco_conn_signal_entry_key (entry)
  (strcat
    (safeStr (_coco_nth 0 entry))
    "@"
    (safeStr (_coco_nth 1 entry))
    ","
    (safeStr (_coco_nth 2 entry))))

(defun _coco_conn_merge_signal_entries (base extra)
  (let ((result base)
        (keys nil)
        (key ""))
    (foreach entry result
      (setq keys (append keys (list (_coco_conn_signal_entry_key entry)))))
    (foreach entry extra
      (setq key (_coco_conn_signal_entry_key entry))
      (when (not (_coco_member_string key keys))
        (setq result (append result (list entry)))
        (setq keys (append keys (list key)))))
    result))

(defun _coco_conn_signal_entries_from_props (props)
  (let ((entries nil)
        (name "")
        (value ""))
    (foreach prop props
      (setq name (upperCase (safeGetProp prop "name")))
      (setq value (safeGetProp prop "value"))
      (when (and
              (_coco_member_string name (list "SIG_NAME" "HDL_POWER" "HDL_TAP"))
              (not (equal value "")))
        (setq entries
          (_coco_conn_merge_signal_entries
            entries
            (list (_coco_conn_signal_prop_entry prop))))))
    entries))

(defun _coco_conn_signal_props_for_page (handle)
  (let ((props nil))
    (setq props
      (_coco_merge_unique_props props (_coco_props_from_find handle "find sig_name=*")))
    (setq props
      (_coco_merge_unique_props props (_coco_props_from_find handle "find hdl_power=*")))
    (setq props
      (_coco_merge_unique_props props (_coco_props_from_find handle "find hdl_tap=*")))
    (_coco_conn_signal_entries_from_props props)))

(defun _coco_conn_signal_prop_names (entries)
  (let ((names nil)
        (name ""))
    (foreach entry entries
      (setq name (safeStr (_coco_nth 0 entry)))
      (when (and
              (not (equal name ""))
              (not (_coco_member_string name names)))
        (setq names (append names (list name)))))
    names))

(defun _coco_conn_named_wires_for_names (handle names)
  (let ((items nil)
        (iter nil)
        (direct_wires nil)
        (net_result nil)
        (net_group "")
        (net_object_set nil)
        (net_wires nil)
        (wire_result nil)
        (wire_group "")
        (wire_object_set nil)
        (wires nil)
        (find_group ""))
    (setq _coco_conn_named_wire_queries nil)
    ; `find sig_name=<name>` + cnGetWires is the same proven path used by
    ; ui_navigate_net. It does not depend on property attach coordinates.
    (foreach name names
      (setq direct_wires nil)
      (setq net_result nil)
      (setq net_group "")
      (setq net_object_set nil)
      (setq net_wires nil)
      (setq wire_result nil)
      (setq wire_group "")
      (setq wire_object_set nil)
      (setq wires nil)
      (setq find_group "")
      (setq iter
        (_coco_open_iterator
          handle
          (sprintf nil "find sig_name=%s" name)
          'cnGetWires))
      (setq direct_wires (_coco_iterator_items iter))
      (setq find_group (_coco_iterator_group iter))
      (when (not (equal find_group ""))
        (setq net_result
          (errset
            (_coco_send_cmd handle (sprintf nil "INCLUDE %s NETS" find_group))
            nil)))
      (when net_result
        (setq net_group
          (safeStr (_coco_safe_apply 'cnGetGroupName (list (car net_result)))))
        (setq net_object_set
          (_coco_safe_apply 'cnGetGroupedObjectSet (list (car net_result))))
        (when net_object_set
          (setq net_wires (_coco_safe_apply 'cnGetWires (list net_object_set)))))
      (when (equal net_group "")
        (setq net_group find_group))
      (when (not (equal net_group ""))
        (setq wire_result
          (errset
            (_coco_send_cmd handle (sprintf nil "INCLUDE %s WIRES" net_group))
            nil)))
      (when wire_result
        (setq wire_group
          (safeStr (_coco_safe_apply 'cnGetGroupName (list (car wire_result)))))
        (setq wire_object_set
          (_coco_safe_apply 'cnGetGroupedObjectSet (list (car wire_result))))
        (when wire_object_set
          (setq wires (_coco_safe_apply 'cnGetWires (list wire_object_set)))))
      (when (not wires)
        (setq wires (if net_wires net_wires direct_wires)))
      (setq _coco_conn_named_wire_queries
        (append
          _coco_conn_named_wire_queries
          (list
            (list
              name
              (length direct_wires)
              (length net_wires)
              (length wires)
              find_group
              wire_group))))
      (foreach wire wires
        (setq items (append items (list (list name wire)))))
      (when (and
              (not (equal wire_group ""))
              (not (equal wire_group net_group))
              (not (equal wire_group find_group)))
        (_coco_cleanup_iterator handle (_coco_make_iterator wire_group nil)))
      (when (and
              (not (equal net_group ""))
              (not (equal net_group find_group)))
        (_coco_cleanup_iterator handle (_coco_make_iterator net_group nil)))
      (_coco_cleanup_iterator handle iter))
    items))

(defun _coco_conn_between_int (value a b)
  (or
    (and (leqp a value) (leqp value b))
    (and (leqp b value) (leqp value a))))

(defun _coco_conn_point_on_wire (x_str y_str wire)
  (let ((x (atoi x_str))
        (y (atoi y_str))
        (x1 (atoi (_coco_conn_wire_x1 wire)))
        (y1 (atoi (_coco_conn_wire_y1 wire)))
        (x2 (atoi (_coco_conn_wire_x2 wire)))
        (y2 (atoi (_coco_conn_wire_y2 wire))))
    (or
      (and (equal y y1)
           (equal y1 y2)
           (_coco_conn_between_int x x1 x2))
      (and (equal x x1)
           (equal x1 x2)
           (_coco_conn_between_int y y1 y2)))))

(defun _coco_conn_net_names_by_signal_props_for_wire (wire)
  (let ((names nil)
        (name "")
        (x "")
        (y ""))
    (foreach entry _coco_conn_page_signal_props
      (setq name (_coco_nth 0 entry))
      (setq x (_coco_nth 1 entry))
      (setq y (_coco_nth 2 entry))
      (when (and (not (equal name ""))
                 (not (equal x ""))
                 (not (equal y ""))
                 (_coco_conn_point_on_wire x y wire)
                 (not (_coco_member_string name names)))
        (setq names (append names (list name)))))
    names))

(defun _coco_conn_prop_attach_key (prop)
  (let ((point (_coco_safe_apply 'cnGetPropAttachXY (list prop)))
        (x "")
        (y ""))
    (when point
      (setq x (safeStr (_coco_safe_apply 'cnGetPointX (list point))))
      (setq y (safeStr (_coco_safe_apply 'cnGetPointY (list point)))))
    (_coco_conn_point_key x y)))

(defun _coco_conn_names_from_props_at_point (props point_key)
  (let ((names nil)
        (name "")
        (value ""))
    (foreach prop props
      (setq name (upperCase (safeGetProp prop "name")))
      (when (and (_coco_member_string name (list "SIG_NAME" "HDL_POWER" "HDL_TAP"))
                 (equal (_coco_conn_prop_attach_key prop) point_key))
        (setq value (safeGetProp prop "value"))
        (when (and (not (equal value ""))
                   (not (_coco_member_string value names)))
          (setq names (append names (list value))))))
    names))

(defun _coco_conn_props_near_point (handle x_str y_str)
  (let ((x (atoi x_str))
        (y (atoi y_str))
        (select_result nil)
        (include_result nil)
        (group "")
        (include_group "")
        (group_obj nil)
        (props nil)
        (result nil))
    (setq result
      (errset
        (_coco_send_cmd
          handle
          (sprintf nil "Select (%d %d) (%d %d)"
            (difference x 5)
            (difference y 5)
            (plus x 5)
            (plus y 5)))
        nil))
    (when result
      (setq select_result (car result))
      (setq group (safeStr (_coco_safe_apply 'cnGetGroupName (list select_result))))
      (setq include_result (errset (_coco_send_cmd handle "include bodies properties") nil))
      (when include_result
        (setq include_group (safeStr (_coco_safe_apply 'cnGetGroupName (list (car include_result)))))
        (setq group_obj (_coco_safe_apply 'cnGetGroupedObjectSet (list (car include_result))))
        (when group_obj
          (setq props (_coco_safe_apply 'cnGetProps (list group_obj)))))
      (when (and (not (equal include_group "")) (not (equal include_group group)))
        (_coco_cleanup_iterator handle (_coco_make_iterator include_group nil)))
      (_coco_cleanup_iterator handle (_coco_make_iterator group nil)))
    props))

(defun _coco_conn_net_names_by_endpoint_props_for_wire (handle wire)
  (let ((names nil)
        (point_key1 (_coco_conn_wire_p1 wire))
        (point_key2 (_coco_conn_wire_p2 wire))
        (props nil)
        (point_names nil))
    (setq props (_coco_conn_props_near_point handle (_coco_conn_wire_x1 wire) (_coco_conn_wire_y1 wire)))
    (setq point_names (_coco_conn_names_from_props_at_point props point_key1))
    (foreach name point_names
      (when (not (_coco_member_string name names))
        (setq names (append names (list name)))))
    (setq props (_coco_conn_props_near_point handle (_coco_conn_wire_x2 wire) (_coco_conn_wire_y2 wire)))
    (setq point_names (_coco_conn_names_from_props_at_point props point_key2))
    (foreach name point_names
      (when (not (_coco_member_string name names))
        (setq names (append names (list name)))))
    names))

(defun _coco_conn_net_names_for_wire (handle wire)
  (let ((props nil)
        (names nil)
        (value ""))
    (setq props (_coco_conn_props_for_wire handle wire t))
    (foreach prop props
      (when (_coco_member_string (upperCase (safeGetProp prop "name")) (list "SIG_NAME" "HDL_POWER" "HDL_TAP"))
        (setq value (safeGetProp prop "value"))
        (when (and (not (equal value ""))
                   (not (_coco_member_string value names)))
          (setq names (append names (list value))))))
    (when (not names)
      (setq names (_coco_conn_net_names_by_signal_props_for_wire wire)))
    (when (not names)
      (setq names (_coco_conn_net_names_by_endpoint_props_for_wire handle wire)))
    names))

(defun _coco_conn_wire_connected_to_wire_p (left right)
  (or
    (_coco_conn_point_on_wire
      (_coco_conn_wire_x1 left) (_coco_conn_wire_y1 left) right)
    (_coco_conn_point_on_wire
      (_coco_conn_wire_x2 left) (_coco_conn_wire_y2 left) right)
    (_coco_conn_point_on_wire
      (_coco_conn_wire_x1 right) (_coco_conn_wire_y1 right) left)
    (_coco_conn_point_on_wire
      (_coco_conn_wire_x2 right) (_coco_conn_wire_y2 right) left)))

(defun _coco_conn_wire_in_list (wire wires)
  (let ((found nil)
        (dbid (_coco_conn_wire_dbid wire)))
    (foreach item wires
      (when (or
              (and
                (not (equal dbid ""))
                (equal dbid (_coco_conn_wire_dbid item)))
              (_coco_conn_same_wire_geometry wire item))
        (setq found t)))
    found))

(defun _coco_conn_wires_at_xy (wires x y)
  (let ((items nil))
    (foreach wire wires
      (when (_coco_conn_point_on_wire x y wire)
        (when (not (_coco_conn_wire_in_list wire items))
          (setq items (append items (list wire))))))
    items))

(defun _coco_conn_trace_wires_from_xy (wires x y)
  (let ((frontier (_coco_conn_wires_at_xy wires x y))
        (result nil)
        (front nil))
    (setq result frontier)
    (while frontier
      (setq front (car frontier))
      (setq frontier (cdr frontier))
      (foreach wire wires
        (when (and
                (not (_coco_conn_wire_in_list wire result))
                (_coco_conn_wire_connected_to_wire_p front wire))
          (setq result (append result (list wire)))
          (setq frontier (append frontier (list wire))))))
    result))

(defun _coco_conn_pin_entry (refdes pin comp_tuple props)
  (list
    refdes
    (_coco_detail_pin_name pin)
    (_coco_detail_pin_x pin)
    (_coco_detail_pin_y pin)
    (safeStr (_coco_nth 1 comp_tuple))
    (_coco_first_nonempty_prop_value props (list "PATH" "Path" "SOURCE_PATH" "INSTANCE" "Instance"))
    (_coco_first_nonempty_prop_value props (list "PART_NAME" "Part Name" "PART_NUMBER"))
    (_coco_first_nonempty_prop_value props (list "DEVICE" "Device"))
    (_coco_first_nonempty_prop_value props (list "PCB Footprint" "PCB_FOOTPRINT" "JEDEC_TYPE" "PACK_TYPE"))))

(defun _coco_conn_net_matches_pin_token (net_name token)
  (and
    (not (equal token ""))
    (_coco_conn_string_contains net_name (strcat "$" token "$"))))

(defun _coco_conn_generated_net_matches_pin_entry (net_name pin_entry)
  (let ((pin_name (safeStr (_coco_nth 1 pin_entry)))
        (symbol_name (safeStr (_coco_nth 4 pin_entry)))
        (path_name (safeStr (_coco_nth 5 pin_entry)))
        (part_name (safeStr (_coco_nth 6 pin_entry)))
        (device (safeStr (_coco_nth 7 pin_entry)))
        (footprint (safeStr (_coco_nth 8 pin_entry)))
        (pin_suffix ""))
    (setq pin_suffix (strcat "$" pin_name))
    (and
      (_coco_conn_string_ends_with net_name pin_suffix)
      (or
        (_coco_conn_net_matches_pin_token net_name symbol_name)
        (_coco_conn_net_matches_pin_token net_name part_name)
        (_coco_conn_net_matches_pin_token net_name device)
        (_coco_conn_net_matches_pin_token net_name footprint)
        (and
          (not (equal path_name ""))
          (_coco_conn_string_contains net_name (strcat "$" path_name "$")))))))

(defun _coco_conn_all_page_pins (handle)
  (let ((refdes_list (_coco_component_refdes_list handle))
        (comp_tuples (_coco_component_tuples handle))
        (items nil)
        (props nil)
        (xy "")
        (comp_tuple nil)
        (sym_info nil)
        (pins nil))
    (foreach refdes refdes_list
      (setq props (_coco_component_props_for_refdes handle refdes))
      (setq xy (_coco_first_nonempty_prop_value props (list "XY")))
      (setq comp_tuple (_coco_find_component_tuple_by_xy xy comp_tuples))
      (when comp_tuple
        (setq sym_info (_coco_safe_apply 'cnGetCompSymInfo (list handle comp_tuple)))
        (when sym_info
          (setq pins (_coco_safe_apply 'cnCreateCompPins (list comp_tuple sym_info)))
          (foreach pin pins
            (setq items (append items (list (_coco_conn_pin_entry refdes pin comp_tuple props))))))))
    items))

(defun _coco_conn_first_string (items)
  (if items (safeStr (car items)) ""))

(defun _coco_conn_generated_net_names_for_pin_entry (pin_entry)
  (let ((names nil)
        (matched nil))
    (foreach net_name _coco_conn_page_net_names
      (setq matched (_coco_conn_generated_net_matches_pin_entry net_name pin_entry))
      (when (and matched (not (_coco_member_string net_name names)))
        (setq names (append names (list net_name)))))
    names))

(defun _coco_conn_net_names_from_wires (handle wires)
  (let ((names nil)
        (wire_names nil))
    ; Signal attachment lookup is in-memory and avoids per-wire CAD commands.
    (foreach wire wires
      (when (not names)
        (setq wire_names (_coco_conn_net_names_by_signal_props_for_wire wire))
        (when wire_names
          (setq names (list (car wire_names))))))
    (foreach wire wires
      (when (not names)
        (setq wire_names (_coco_conn_net_names_for_wire handle wire))
        (when wire_names
          (setq names (list (car wire_names))))))
    (if names (list (car names)) nil)))
